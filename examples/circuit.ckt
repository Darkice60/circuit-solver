I1 0 n1 0.005
R1 n1 0 1000
R2 n1 n2 2000
R3 n2 0 1000
