V1 n1 0 20
R1 n1 n2 2
C1 n2 n3 0.0001
R2 n3 0 4
.tran 0.0005 0.005 uic
